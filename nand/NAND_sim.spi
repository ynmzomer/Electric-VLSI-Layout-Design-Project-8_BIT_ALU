*** SPICE deck for cell NAND_sim{sch} from library NandGate
*** Created on Cum Ara 12, 2025 19:18:17
*** Last revised on Cum Ara 12, 2025 23:03:57
*** Written on Cum Ara 12, 2025 23:04:10 by Electric VLSI Design System, version 9.08
*** Layout tech: mocmos, foundry MOSIS
*** UC SPICE *** , MIN_RESIST 4.0, MIN_CAPAC 0.1FF

*** SUBCIRCUIT NandGate__NAND FROM CELL NAND{sch}
.SUBCKT NandGate__NAND A AB B
** GLOBAL gnd
** GLOBAL vdd
Mnmos@0 AB A net@5 gnd N L=0.6U W=3U
Mnmos@1 net@5 B gnd gnd N L=0.6U W=3U
Mpmos@0 vdd A AB vdd P L=0.6U W=3U
Mpmos@1 vdd B AB vdd P L=0.6U W=3U
.ENDS NandGate__NAND

.global gnd vdd

*** TOP LEVEL CELL: NAND_sim{sch}
XNAND@1 A AB B NandGate__NAND

* Spice Code nodes in cell cell 'NAND_sim{sch}'
vdd vdd 0 DC 5
va A 0 DC pwl 10n 0 20n 5 50n 5 60n 0 90n 0 100n 5 130n 5 140n 0 170n 0 180n 5
vb B 0 DC pwl 10n 0 20n 5 100n 5 110n 0
.measure tran tf trig v(AB) val=4.5 fall=1 td=4ns targ v(AB) val=0.5 fall=1
.measure tran tr trig v(AB) val=0.5 rise=1 td=4ns targ v(AB) val=4.5 rise=1
.tran 200n
.include C:\Users\omery\Desktop\C5_models.txt
* Trailer cards described in this file:
.include C:\Users\omery\Desktop\C5_models.txt
.END
