*** SPICE deck for cell mux2x1{lay} from library mux_2_1
*** Created on Çar Ara 17, 2025 22:01:30
*** Last revised on Çar Ara 17, 2025 22:53:42
*** Written on Çar Ara 17, 2025 22:53:49 by Electric VLSI Design System, version 9.08
*** Layout tech: mocmos, foundry MOSIS
*** UC SPICE *** , MIN_RESIST 4.0, MIN_CAPAC 0.1FF

*** SUBCIRCUIT Inverter__Inv FROM CELL Inv{lay}
.SUBCKT Inverter__Inv gnd in out vdd
Mnmos@0 gnd in out gnd N L=0.6U W=3U AS=6.75P AD=18P PS=10.5U PD=28.5U
Mpmos@0 vdd in out vdd P L=0.6U W=3U AS=6.75P AD=20.25P PS=10.5U PD=29.1U
.ENDS Inverter__Inv

*** TOP LEVEL CELL: mux_2_1:mux2x1{lay}
XInv@0 gnd S net@31 vdd Inverter__Inv
Mnmos@0 Y S D1 gnd N L=0.6U W=3.6U AS=7.56P AD=7.56P PS=11.4U PD=11.4U
Mnmos@1 D0 net@31 Y gnd N L=0.6U W=3.6U AS=7.56P AD=7.56P PS=11.4U PD=11.4U
Mpmos@0 D1 net@31 Y vdd P L=0.6U W=3.6U AS=7.56P AD=7.56P PS=11.4U PD=11.4U
Mpmos@1 Y S D0 vdd P L=0.6U W=3.6U AS=7.56P AD=7.56P PS=11.4U PD=11.4U

* Spice Code nodes in cell cell 'mux_2_1:mux2x1{lay}'
VDD vdd 0 DC 5
VS  S   0 PWL(0n 0 40n 0 50n 0 60n 5 90n 5 120n 5)
VD0 D0  0 PWL(0n 0 20n 0 30n 5 60n 5 70n 0 80n 0 90n 5)
VD1 D1  0 PWL(0n 5 20n 5 40n 5 50n 0 60n 5 100n 5 110n 0)
Cload Y 0 250fF
.tran 0 120n
.include C:\Users\omery\Desktop\C5_models.txt
* Trailer cards described in this file:
.include C:\Users\omery\Desktop\C5_models.txt
.END
