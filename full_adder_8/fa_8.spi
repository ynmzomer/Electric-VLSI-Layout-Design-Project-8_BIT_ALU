*** SPICE deck for cell fa_8{lay} from library full_adder_8
*** Created on Per Ara 18, 2025 20:44:04
*** Last revised on Cum Ara 19, 2025 23:38:05
*** Written on Cum Ara 19, 2025 23:39:00 by Electric VLSI Design System, version 9.08
*** Layout tech: mocmos, foundry MOSIS
*** UC SPICE *** , MIN_RESIST 4.0, MIN_CAPAC 0.1FF

*** SUBCIRCUIT Inverter__Inv FROM CELL Inverter:Inv{lay}
.SUBCKT Inverter__Inv gnd in out vdd
Mnmos@0 gnd in out gnd N L=0.6U W=3U AS=6.75P AD=18P PS=10.5U PD=28.5U
Mpmos@0 vdd in out vdd P L=0.6U W=3U AS=6.75P AD=20.25P PS=10.5U PD=29.1U
.ENDS Inverter__Inv

*** SUBCIRCUIT NorGate__NOR FROM CELL NorGate:NOR{lay}
.SUBCKT NorGate__NOR A AorB B gnd vdd
Mnmos@0 gnd A AorB gnd N L=0.6U W=3U AS=5.25P AD=13.5P PS=7.5U PD=21U
Mnmos@1 AorB B gnd gnd N L=0.6U W=3U AS=13.5P AD=5.25P PS=21U PD=7.5U
Mpmos@0 vdd A net@6 vdd P L=0.6U W=3U AS=2.25P AD=22.95P PS=4.5U PD=32.1U
Mpmos@1 net@6 B AorB vdd P L=0.6U W=3U AS=5.25P AD=2.25P PS=7.5U PD=4.5U
.ENDS NorGate__NOR

*** SUBCIRCUIT NandGate__NAND FROM CELL NandGate:NAND{lay}
.SUBCKT NandGate__NAND A AB B gnd vdd
Mnmos@1 AB A net@6 gnd N L=0.6U W=3U AS=2.7P AD=5.25P PS=4.8U PD=7.5U
Mnmos@2 net@6 B gnd gnd N L=0.6U W=3U AS=20.25P AD=2.7P PS=31.5U PD=4.8U
Mpmos@0 vdd A AB vdd P L=0.6U W=3U AS=5.25P AD=13.5P PS=7.5U PD=21U
Mpmos@1 AB B vdd vdd P L=0.6U W=3U AS=13.5P AD=5.25P PS=21U PD=7.5U
.ENDS NandGate__NAND

*** SUBCIRCUIT XorGate__XOR FROM CELL XorGate:XOR{lay}
.SUBCKT XorGate__XOR A B gnd out vdd
Mnmos@0 net@6 A out gnd N L=0.6U W=3U AS=4.275P AD=5.4P PS=5.85U PD=8.1U
Mnmos@1 out net@17 net@6 gnd N L=0.6U W=3U AS=5.4P AD=4.275P PS=8.1U PD=5.85U
Mnmos@2 net@6 net@28 gnd gnd N L=0.6U W=3U AS=17.775P AD=5.4P PS=25.35U PD=8.1U
Mnmos@3 gnd B net@6 gnd N L=0.6U W=3U AS=5.4P AD=17.775P PS=8.1U PD=25.35U
Mnmos@4 gnd A net@28 gnd N L=0.6U W=3U AS=6.75P AD=17.775P PS=10.5U PD=25.35U
Mnmos@5 net@17 B gnd gnd N L=0.6U W=3U AS=17.775P AD=6.75P PS=25.35U PD=10.5U
Mpmos@0 vdd A net@1 vdd P L=0.6U W=3U AS=2.25P AD=21.6P PS=4.5U PD=27.9U
Mpmos@2 net@1 net@17 out vdd P L=0.6U W=3U AS=4.275P AD=2.25P PS=5.85U PD=4.5U
Mpmos@3 out net@28 net@4 vdd P L=0.6U W=3U AS=2.7P AD=4.275P PS=4.8U PD=5.85U
Mpmos@4 net@4 B vdd vdd P L=0.6U W=3U AS=21.6P AD=2.7P PS=27.9U PD=4.8U
Mpmos@5 vdd A net@28 vdd P L=0.6U W=3U AS=6.75P AD=21.6P PS=10.5U PD=27.9U
Mpmos@6 net@17 B vdd vdd P L=0.6U W=3U AS=21.6P AD=6.75P PS=27.9U PD=10.5U
.ENDS XorGate__XOR

*** SUBCIRCUIT half_adder__ha FROM CELL half_adder:ha{lay}
.SUBCKT half_adder__ha A B C gnd OUT vdd
XInv@1 gnd net@52 C vdd Inverter__Inv
XNAND@0 A net@52 B gnd vdd NandGate__NAND
XXOR@0 A B gnd OUT vdd XorGate__XOR
.ENDS half_adder__ha

*** SUBCIRCUIT full_adder__fa FROM CELL full_adder:fa{lay}
.SUBCKT full_adder__fa A B C_in C_out gnd S vdd
XInv@0 gnd net@8 C_out vdd Inverter__Inv
XNOR@0 net@26 net@8 net@84 gnd vdd NorGate__NOR
Xha@0 C_in net@62 net@26 gnd S vdd half_adder__ha
Xha@1 A B net@84 gnd net@62 vdd half_adder__ha
.ENDS full_adder__fa

*** TOP LEVEL CELL: fa_8{lay}
Xfa@0 A0 B0 fa@0_C_in net@10 gnd S0 vdd full_adder__fa
Xfa@1 A1 B1 net@10 net@15 gnd S1 vdd full_adder__fa
Xfa@2 A2 B2 net@15 net@21 gnd S2 vdd full_adder__fa
Xfa@3 A3 B3 net@21 net@115 gnd S3 vdd full_adder__fa
Xfa@4 A4 B4 net@115 net@130 gnd S4 vdd full_adder__fa
Xfa@5 A5 B5 net@130 net@26 gnd S5 vdd full_adder__fa
Xfa@6 A6 B6 net@26 net@29 gnd S6 vdd full_adder__fa
Xfa@7 A7 B7 net@29 C_out gnd S7 vdd full_adder__fa

* Spice Code nodes in cell cell 'fa_8{lay}'
vdd vdd 0 DC 5
va0 A0 0 DC pwl 10n 0 20n 5 50n 5 60n 0
vb0 B0 0 DC pwl 10n 0 20n 5 50n 5 60n 0
va1 A1 0 DC pwl 10n 0 20n 5 50n 5 60n 0
vb1 B1 0 DC pwl 10n 0 20n 0 50n 0 60n 0
va2 A2 0 DC pwl 10n 0 20n 0 50n 0 60n 0
vb2 B2 0 DC pwl 10n 0 20n 5 50n 5 60n 0
va3 A3 0 DC pwl 10n 0 20n 0 50n 0 60n 0
vb3 B3 0 DC pwl 10n 0 20n 5 50n 5 60n 0
va4 A4 0 DC pwl 10n 0 20n 5 50n 5 60n 0
vb4 B4 0 DC pwl 10n 0 20n 5 50n 5 60n 0
va5 A5 0 DC pwl 10n 0 20n 5 50n 5 60n 0
vb5 B5 0 DC pwl 10n 0 20n 0 50n 0 60n 0
va6 A6 0 DC pwl 10n 0 20n 0 50n 0 60n 0
vb6 B6 0 DC pwl 10n 0 20n 0 50n 0 60n 0
va7 A7 0 DC pwl 10n 0 20n 5 50n 5 60n 0
vb7 B7 0 DC pwl 10n 0 20n 5 50n 5 60n 0
.tran 200n
.include C:\Users\omery\Desktop\C5_models.txt
* Trailer cards described in this file:
.include C:\Users\omery\Desktop\C5_models.txt
.END
