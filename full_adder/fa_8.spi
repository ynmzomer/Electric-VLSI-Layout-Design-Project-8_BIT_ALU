*** SPICE deck for cell fa_8{sch} from library full_adder_8
*** Created on Per Ara 18, 2025 19:53:31
*** Last revised on Per Ara 18, 2025 20:23:27
*** Written on Per Ara 18, 2025 20:23:35 by Electric VLSI Design System, version 9.08
*** Layout tech: mocmos, foundry MOSIS
*** UC SPICE *** , MIN_RESIST 4.0, MIN_CAPAC 0.1FF

*** SUBCIRCUIT Inverter__Inv FROM CELL Inverter:Inv{sch}
.SUBCKT Inverter__Inv in out
** GLOBAL gnd
** GLOBAL vdd
Mnmos@0 out in gnd gnd N L=0.6U W=3U
Mpmos@0 vdd in out vdd P L=0.6U W=3U
.ENDS Inverter__Inv

*** SUBCIRCUIT NorGate__NOR FROM CELL NorGate:NOR{sch}
.SUBCKT NorGate__NOR A AorB B
** GLOBAL gnd
** GLOBAL vdd
Mnmos@0 AorB B gnd gnd N L=0.6U W=3U
Mnmos@1 AorB A gnd gnd N L=0.6U W=3U
Mpmos@0 vdd A net@1 vdd P L=0.6U W=3U
Mpmos@1 net@1 B AorB vdd P L=0.6U W=3U
.ENDS NorGate__NOR

*** SUBCIRCUIT NandGate__NAND FROM CELL NandGate:NAND{sch}
.SUBCKT NandGate__NAND A AB B
** GLOBAL gnd
** GLOBAL vdd
Mnmos@0 AB A net@5 gnd N L=0.6U W=3U
Mnmos@1 net@5 B gnd gnd N L=0.6U W=3U
Mpmos@0 vdd A AB vdd P L=0.6U W=3U
Mpmos@1 vdd B AB vdd P L=0.6U W=3U
.ENDS NandGate__NAND

*** SUBCIRCUIT XorGate__XOR FROM CELL XorGate:XOR{sch}
.SUBCKT XorGate__XOR A B out
** GLOBAL gnd
** GLOBAL vdd
Mnmos@0 out A net@15 gnd N L=0.6U W=3U
Mnmos@1 out net@53 net@15 gnd N L=0.6U W=3U
Mnmos@2 net@15 B gnd gnd N L=0.6U W=3U
Mnmos@3 net@15 net@50 gnd gnd N L=0.6U W=3U
Mpmos@0 vdd A net@2 vdd P L=0.6U W=3U
Mpmos@1 net@2 net@53 out vdd P L=0.6U W=3U
Mpmos@3 vdd B net@3 vdd P L=0.6U W=3U
Mpmos@4 net@3 net@50 out vdd P L=0.6U W=3U
XInv@4 A net@50 Inverter__Inv
XInv@5 B net@53 Inverter__Inv
.ENDS XorGate__XOR

*** SUBCIRCUIT half_adder__ha FROM CELL half_adder:ha{sch}
.SUBCKT half_adder__ha A B C OUT
** GLOBAL gnd
** GLOBAL vdd
XInv@0 net@4 C Inverter__Inv
XNAND@0 A net@4 B NandGate__NAND
XXOR@0 A B OUT XorGate__XOR
.ENDS half_adder__ha

*** SUBCIRCUIT full_adder__fa FROM CELL fa{sch}
.SUBCKT full_adder__fa A B C_in C_out S
** GLOBAL gnd
** GLOBAL vdd
XInv@0 net@3 C_out Inverter__Inv
XNOR@0 net@8 net@3 net@4 NorGate__NOR
Xha@0 C_in net@20 net@8 S half_adder__ha
Xha@1 A B net@4 net@20 half_adder__ha
.ENDS full_adder__fa

.global gnd vdd

*** TOP LEVEL CELL: full_adder_8:fa_8{sch}
Xfa@0 A7 B7 net@31 C_out S7 full_adder__fa
Xfa@1 A6 B6 net@26 net@31 S6 full_adder__fa
Xfa@2 A5 B5 net@21 net@26 S5 full_adder__fa
Xfa@3 A4 B4 net@16 net@21 S4 full_adder__fa
Xfa@4 A3 B3 net@11 net@16 S3 full_adder__fa
Xfa@5 A2 B2 net@6 net@11 S2 full_adder__fa
Xfa@6 A1 B1 net@1 net@6 S1 full_adder__fa
Xfa@7 A0 B0 fa@7_C_in net@1 S0 full_adder__fa

* Spice Code nodes in cell cell 'full_adder_8:fa_8{sch}'
vdd vdd 0 DC 5
va0 A0 0 DC pwl 10n 0 20n 5 50n 5 60n 0
vb0 B0 0 DC pwl 10n 0 20n 5 50n 5 60n 0
va1 A1 0 DC pwl 10n 0 20n 5 50n 5 60n 0
vb1 B1 0 DC pwl 10n 0 20n 0 50n 0 60n 0
va2 A2 0 DC pwl 10n 0 20n 0 50n 0 60n 0
vb2 B2 0 DC pwl 10n 0 20n 5 50n 5 60n 0
va3 A3 0 DC pwl 10n 0 20n 0 50n 0 60n 0
vb3 B3 0 DC pwl 10n 0 20n 5 50n 5 60n 0
va4 A4 0 DC pwl 10n 0 20n 5 50n 5 60n 0
vb4 B4 0 DC pwl 10n 0 20n 5 50n 5 60n 0
va5 A5 0 DC pwl 10n 0 20n 5 50n 5 60n 0
vb5 B5 0 DC pwl 10n 0 20n 0 50n 0 60n 0
va6 A6 0 DC pwl 10n 0 20n 0 50n 0 60n 0
vb6 B6 0 DC pwl 10n 0 20n 0 50n 0 60n 0
va7 A7 0 DC pwl 10n 0 20n 5 50n 5 60n 0
vb7 B7 0 DC pwl 10n 0 20n 5 50n 5 60n 0
.tran 200n
.include C:\Users\omery\Desktop\C5_models.txt
* Trailer cards described in this file:
.include C:\Users\omery\Desktop\C5_models.txt
.END
